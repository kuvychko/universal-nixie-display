* FAULT TEST, TUBE DARK (variant of fault_fbopen.cir): feedback divider top open, so FB falls to 0 V and the LM5156 runs at its
* current limit. Protection: the shared monitor / OVP divider (HHV-25 2.7M - MON - 7.87k - OVP tap -
* 6.19k, trip 544.6 V; since 2026-10-07; earlier runs 4.64M / 10.5k, 551.8 V, and 4.7M / 10.7k, 548.4 V) into the HV OVP
* comparator, and the V_b OVP (2.2M / 13.7k, 200.7 V). CMON is the ADC reservoir on MON (C304).
* Derived from fault_d5open.cir (all tripler diodes present).
* HV supply warm start: stack precharged to its operating voltages, so regulation is reached in
* ~1 ms instead of a full cold start. Feedback from HV (decided after
* comparing with V_b feedback, which left HV at 442 V with a dark tube). The precharged stack
* (435 V) is above the assumed strike voltage, so the tube strikes at once.
*
* Purpose (Phase 1B power sheet): start-up into a dark tube, tube strike, steady state at the
* 450 V setpoint. Measures V_b / HV regulation, inductor peak vs. current limit, switch-node peak
* (MOSFET stress), capacitor and diode stress, and RTN-side tube current.
*
* Values: Phase 1B draft (docs/hardware.md, "Power sheet"). The LM5156 model is TI's (see
* README.md); MOSFET, diodes and the tube are approximate generic models written for this bench:
*   M1  ~ AOD5N40    (400 V, Vth 4.0 V worst-ish case of 3.4-4.5 V, Rds(on) ~1.2-1.6 ohm at 10 V)
*   D*  ~ ES1J       (600 V, trr 35 ns)
*   Tube: dark until anode-cathode > V_STRIKE, then a 150 V maintaining drop until the current
*         falls below hold. V_STRIKE = 380 V is an assumption, not tube data; the A101 data gives
*         only the supply voltage (425 V min). Cathodes return to an ideal 50 V RTN source.
* Run from this directory:  ngspice_con -b hv_startup.cir > hv_startup.log

.include models/vendor/ti/LM5156-Q1_PSPICE_TRANS/LM5156-Q1_TRANS.ngspice.lib

* Tube held dark: strike voltage out of reach, latch starts clear
.param VSTRIKE=1e4 VMAINT=150 VRTN=50 RGATE=2
* Comparator edge: 200 /V (as fault_fbopen.cir) behaves as a soft clamp, sinking enough current 13 mV
* below the threshold to pull EN part-way; 20000 /V (0.1 mV wide) approximates the real comparator
.param KCMP=20000

VIN   vin  0  12
* HV_EN: on at 100 us through 10k, 100k pull-down on EN/UVLO
VEN   en_drv 0 PULSE(0 3.3 100u 1u 1u 1 2)
REN   en_drv uvlo 10k
RPD   uvlo 0 100k

* BIAS = VCC from the 10 V gate-drive regulator (LP2951; LM5156 BIAS=VCC mode, 2.97-16 V)
VDRV  vdrv 0 10
XU1   vdrv comp cs vdrv fb gate 0 pgood rt ss uvlo vdrv LM5156-Q1_TRANS
* 147k: ~150 kHz (kit inductor design)
RRT   rt 0 147k
CSS   ss 0 2.2n
RC    comp c1 10k
CC    c1 0 10n
CHF   comp 0 100p
RPG   pgood v3 100k
V3    v3 0 3.3

* Boost stage
CIN   vin 0 22u
* Kit inductor: 100 uH +/-10 %, DCR 0.35 ohm; simulated at the -10 % corner
L1    vin lx 90u
RL1   lx sw 0.35
RG    gate g1 {RGATE}
M1    sw g1 src M250
RS    src 0 0.22
* CS filter: the pump capacitors recharge through the switch at turn-on, a current spike that would
* otherwise reach the CS pin (abs max 0.3 V) directly
RCSF  src cs 100
CCSF  cs 0 470p
D1    sw vb DES1J
XC1   vb 0 CFILM
* Feedback: V_b = 1.00 V * (1 + 1.5M / 10.07k) = 150 V
* Feedback top open (fault)
RFT   hv fb 1T
RFB   fb 0 5.97k

* V_b OVP: 2.2M / 13.7k into a TLV3011 (1.242 V); HV OVP: shared divider below. Comparators as
* smooth current sinks on the EN/UVLO node (open drain), 6 us comparator delay ignored.
RVO1  vb vbs 2.2Meg
RVO2  vbs 0 13.7k
CVO   vbs 0 1n
.param CMON=10n
RMT   hv mon 2.7Meg
CMONC mon 0 {CMON}
RMM   mon hvs 7.87k
RHO2  hvs 0 6.19k
CHO   hvs 0 1n
BOVPV uvlo 0 I = 0.5*(1+tanh((V(vbs)-1.242)*{KCMP})) * V(uvlo)/20
BOVPH uvlo 0 I = 0.5*(1+tanh((V(hvs)-1.242)*{KCMP})) * V(uvlo)/20
RBLB  vb 0 2.2Meg
* G+/RTN regulator feed on the tube sheet (2 x 20k into 90 V): 1.7 mA at V_b 157 V, as 92k to ground
RBIASF vb 0 92k

* Series-stack tripler: every capacitor and diode sees at most V_b
* Film capacitors with ESR: without it the switch / pump-capacitor / diode loop has no impedance and
* the solver fails ("timestep too small" at node cs) at the first hard pump edges. ESL is left out:
* nH-scale parasitics ring at ~100 MHz, which a 5 ns step cannot resolve.
* Pump surge resistor: limits the pump-capacitor recharge current that flows through the switch
* at turn-on (14 A spike, 0.99 V at CS without it; 1.9 A and <= 0.1 V at CS with 47 ohm)
RPUMP sw swp 47
XCP1  swp p1 CFILM
XCP2  p1 p2 CFILM
XC2   vb n2 CFILM
XC3   n2 hv CFILM
.subckt CFILM a b
C1 a m 0.47u
R1 m b 0.1
.ends
D2    vb p1 DES1J
D3    p1 n2 DES1J
D4    n2 p2 DES1J
D5    p2 hv DES1J

* Anode string 3 x 220k, then the tube model to the 50 V RTN
RA    hv anode 660k
* Tube: behavioural, with no hard edges (a hysteretic SW element and a conditional latch both
* stalled the solver). A strike latch sets when anode-cathode exceeds VSTRIKE and clears when it falls to VMAINT + 5 V; it is
* smoothed by a 1 us RC. While lit, current rises smoothly above VMAINT through ~1 kohm dynamic
* resistance.
* Smooth latch: s1 = strike step, s2 = "still above extinction" step; lat = s1 + (1 - s1) * s2 * latf
* Strike is judged on V(hv,rtn), the voltage the anode would have while dark (no current through
* the anode string); judging it on V(anode,rtn) is circular and lets the model settle with a small
* pre-strike current holding the anode just below VSTRIKE. Extinction uses the actual anode voltage.
BLATCH lat 0 V = 0.5*(1+tanh((V(hv,rtn)-{VSTRIKE})/2)) + (1-0.5*(1+tanh((V(hv,rtn)-{VSTRIKE})/2))) * 0.5*(1+tanh((V(anode,rtn)-{VMAINT}-5)/2)) * V(latf)
RLAT   lat latf 1k
CLAT   latf 0 1n
* Current is gated by a sharp function of the latch (0.5*(1+tanh(200*(latf-0.5)))): a partly-set
* latch must not leak current, or a dark tube draws enough through the anode string to never strike
BTUBE  anode rtn I = 0.5*(1+tanh(200*(V(latf)-0.5))) * (0.5/1k) * ((V(anode,rtn)-{VMAINT}) + sqrt((V(anode,rtn)-{VMAINT})^2 + 1))
RTLEAK anode rtn 10G
VRTNS  rtn 0 {VRTN}

.model M250 VDMOS(nchan Vto=4.0 Kp=2 Rd=1.0 Rs=0.1 Cgdmax=60p Cgdmin=5p Cgs=350p Cjo=40p Is=1e-12 Rb=0.2 BV=400)
.model DES1J_OPEN D(Is=1e-20 N=1 Rs=1e9 Cjo=1p)
.model DES1J D(Is=5e-9 Rs=0.15 N=1.9 Cjo=12p Tt=25n BV=600 Ibv=1u)

* Starts at 540 V on the runaway ramp, 12 V below the trip, with the sense taps 1.6 V of HV behind
* (as measured on the ramp in fault_fbopen.cir), and no tube current.
* Result, 2.7M divider (2.7M / 7.87k / 6.19k, trip 544.6 V), KCMP = 20000: trips at 0.76 ms with HV
* at 545.8 V; HV peak 546.0 V, V_b peak 185.9 V, switch node 186.8 V; bursts at 543.5-545.4 V.
* 4.7M / 14.0k / 10.7k (trip 548.4 V): tripped at 550.3 V, bursts 547.1-549.7 V.
* First run (4.64M / 10.5k, trip 551.8 V), KCMP = 20000: OVP trips at 1.76 ms with HV at 553.4 V (551.8 V trip + the
* 1.6 V tap lag); HV peak 553.5 V, V_b peak 188.6 V (V_b OVP 201.6 V, not reached), switch node
* 189.5 V (400 V MOSFET: 2.1x). EN falls to ~0 V, rises again as HV drops below the trip, and the
* converter bursts: HV stays between 550.3 and 553.0 V until the end (4 ms). The hardware OVP does
* not latch; firmware must drop HV_EN. KCMP = 200 (soft edge, as fault_fbopen.cir): HV clamps at
* 544-547.6 V with EN held part-way (0.77-1.6 V).
.ic v(vb)=185 v(sw)=12 v(swp)=12 v(p1)=197 v(n2)=366 v(p2)=378 v(hv)=540 v(latf)=0 v(lat)=0
+ v(mon)=2.789 v(hvs)=1.228 v(xc1.m)=0 v(xcp1.m)=197 v(xcp2.m)=378 v(xc2.m)=366 v(xc3.m)=540
* Relaxed tolerances: with defaults the TI model stalls the solver at light-load mode changes
.options reltol=0.003 abstol=1n vntol=10u chgtol=1e-13 itl4=50
.tran 5n 4m 0 5n uic
.control
run
rusage totaltime
meas tran t_trip WHEN v(uvlo)=1.0 FALL=1
meas tran hv_max MAX v(hv) from=0 to=4m
meas tran vb_max MAX v(vb) from=0 to=4m
meas tran mon_max MAX v(mon) from=0 to=4m
meas tran hvs_max MAX v(hvs) from=0 to=4m
meas tran hv_end FIND v(hv) AT=4m
meas tran hv_at_trip FIND v(hv) WHEN v(uvlo)=1.0 FALL=1
meas tran vsw_pk MAX v(sw) from=0 to=4m
meas tran hv_min_after MIN v(hv) from=2m to=4m
meas tran hv_max_after MAX v(hv) from=2m to=4m
meas tran uvlo_min MIN v(uvlo) from=0.2m to=4m
meas tran uvlo_max_after MAX v(uvlo) from=2m to=4m
meas tran n_restart WHEN v(uvlo)=1.5 RISE=LAST
.endc
.end
