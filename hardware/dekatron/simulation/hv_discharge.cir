* HV discharge after HV_EN falls: passive paths only (D12 target: every node < 50 V within 10 s)
*
* Starts from the 450 V operating state with the converter stopped (switch off), so the
* switch node rests at V_IN through the inductor. Paths (no dedicated HV bleeder since the 0207
* rework): feedback divider HHV-25 2.7M + 6k (2 x 3.0k) and the shared monitor / OVP divider HHV-25 2.7M +
* 7.87k + 6.2k at HV (2.7M tops since 2026-10-07; earlier runs 4.75M / 4.64M and 4.7M); at V_b the V_b bleeder 2.2M and the V_b OVP divider 2.2M + 13.7k; the tube
* until it extinguishes. Three cases: both HV dividers intact, feedback top open, monitor top open
* (single-fault discharge). Same tripler as
* hv_startup.cir. Diodes are a generic ES1J-like model; capacitor values are the draft 0.47 uF.
* Run from this directory:  ngspice_con -b hv_discharge.cir > hv_discharge.log

.param VB0=150 VSTRIKE=380 VMAINT=150 VRTN=50

VIN   vin 0 12
L1    vin lx 100u
RL1   lx sw 0.18
* MOSFET off: drain-source leakage and capacitance only
CDS   sw 0 90p
D1    sw vb DES1J
C1    vb 0 0.47u
.param RFTV=2.7Meg RMTV=2.7Meg
* Feedback divider from HV (HHV-25 4.75M / 10.5k) and a V_b bleeder (HHV-25 2.2M): V_b needs its own
* path when link L3 separates the boost from the tripler during bring-up; V_b OVP divider 2.2M / 13.7k (2.4M, 2.0M / 12.4k until 2026-10-07)
RFT   hv fb {RFTV}
RFB   fb 0 6k
RBLB  vb 0 2.2Meg
RVO1  vb vbs 2.2Meg
RVO2  vbs 0 13.7k

RPUMP sw swp 47
CP1   swp p1 0.47u
CP2   p1 p2 0.47u
C2    vb n2 0.47u
C3    n2 hv 0.47u
D2    vb p1 DES1J
D3    p1 n2 DES1J
D4    n2 p2 DES1J
D5    p2 hv DES1J

* Shared monitor / OVP divider: HV - 4.64M - MON (ADC) - 14.0k - OVP tap - 10.5k - GND
RMT   hv mon {RMTV}
RMM   mon hvs 7.87k
RMO   hvs 0 6.2k
RA    hv anode 660k
* Tube: behavioural, with no hard edges (a hysteretic SW element and a conditional latch both
* stalled the solver). A strike latch sets when anode-cathode exceeds VSTRIKE and clears when it falls to VMAINT + 5 V; it is
* smoothed by a 1 us RC. While lit, current rises smoothly above VMAINT through ~1 kohm dynamic
* resistance.
* Smooth latch: s1 = strike step, s2 = "still above extinction" step; lat = s1 + (1 - s1) * s2 * latf
* Strike is judged on V(hv,rtn), the voltage the anode would have while dark (no current through
* the anode string); judging it on V(anode,rtn) is circular and lets the model settle with a small
* pre-strike current holding the anode just below VSTRIKE. Extinction uses the actual anode voltage.
BLATCH lat 0 V = 0.5*(1+tanh((V(hv,rtn)-{VSTRIKE})/2)) + (1-0.5*(1+tanh((V(hv,rtn)-{VSTRIKE})/2))) * 0.5*(1+tanh((V(anode,rtn)-{VMAINT}-5)/2)) * V(latf)
RLAT   lat latf 1k
CLAT   latf 0 1n
* Current is gated by a sharp function of the latch (0.5*(1+tanh(200*(latf-0.5)))): a partly-set
* latch must not leak current, or a dark tube draws enough through the anode string to never strike
BTUBE  anode rtn I = 0.5*(1+tanh(200*(V(latf)-0.5))) * (0.5/1k) * ((V(anode,rtn)-{VMAINT}) + sqrt((V(anode,rtn)-{VMAINT})^2 + 1))
RTLEAK anode rtn 10G
VRTNS  rtn 0 {VRTN}

.model DES1J D(Is=5e-9 Rs=0.15 N=1.9 Cjo=12p Tt=25n BV=600 Ibv=1u)

* Operating state at stop: switch node at V_IN, each capacitor holding V_b. Set as node voltages:
* per-capacitor IC= with uic is not honoured around this series stack (it starts with hv < 0).
.ic v(latf)=1 v(lat)=1 v(sw)=12 v(swp)=12 v(vb)={VB0} v(p1)={VB0+12} v(n2)={2*VB0} v(p2)={2*VB0+12} v(hv)={3*VB0}
.tran 1m 15 0 5m
.control
let k = 0
foreach case intact fb_open mon_open
  if k = 1
    alterparam RFTV=1T
    reset
  end
  if k = 2
    alterparam RFTV=2.7Meg
    alterparam RMTV=1T
    reset
  end
  echo "=== case $case"
  run
  foreach n hv n2 vb p1 p2
    meas tran t50_$n WHEN v($n)=50 FALL=LAST
  end
  meas tran v10_hv FIND v(hv) AT=10
  meas tran hv_t0  FIND v(hv) AT=1m
  let k = k + 1
end
.endc
.end
